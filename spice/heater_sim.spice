* =====================================================================
* saptest1 Heater Section — Complete SPICE Simulation
* =====================================================================
*
* Timeline:
*   0-100ms:    Boot (TPL5010 POR pulse at 5-65ms, PGOOD at 100ms)
*   100ms-1.2s: Arming delay (C_arm charges through R_arm)
*   2-4s:       Normal heater pulse #1 (PA8 HIGH)
*   6-7.96s:    Normal heater pulse #2
*   8s:         Watchdog fault (RSTn goes LOW)
*   9-11s:      PA8 retries heater (should fail — latch holds)
*
* Key nodes to watch:
*   pa8         MCU timer output
*   gate_node   Q1 gate (should reach ~10V when heater ON)
*   heater_lo   Heater current indicator (= I * Rds)
*   pnp_coll    Latch output / Q4 gate driver
*   arm_node    PGOOD arming RC ramp
*   rstn        Watchdog reset trigger
*

* =====================================================================
* Power Supplies
* =====================================================================
V_24V   v24  0  DC 24
V_3V3   v3v3 0  DC 3.3

* =====================================================================
* Stimulus Sources
* =====================================================================

* PA8: heater pulses at 2-4s, 6-7.96s, retry 9-11s (latch should block)
V_PA8   pa8  0  PWL(
+ 0     0
+ 2     0      2.001  3.3
+ 4     3.3    4.001  0
+ 6     0      6.001  3.3
+ 7.96  3.3    7.961  0
+ 9     0      9.001  3.3
+ 11    3.3    11.001 0 )

* PGOOD: buck regulator stabilizes at ~100ms
V_PGOOD pgood 0  PWL( 0 0  0.099 0  0.1 3.3 )

* RSTn: POR pulse at 5-65ms (boot), fault pulse at 8-8.1s
V_RSTN  rstn  0  PWL(
+ 0      3.3
+ 0.005  3.3   0.00501 0
+ 0.065  0     0.06501 3.3
+ 8      3.3   8.001   0
+ 8.1    0     8.101   3.3 )

* =====================================================================
* Heater Power Path
* =====================================================================

* Fuse (small series R)
R_fuse    v24       fused_24v  0.05

* Heater load: 5 ohms (8 parallel 40-ohm heaters)
R_heater  fused_24v heater_lo  5

* Flyback Schottky across heater (reverse biased during normal op)
D_flyback heater_lo fused_24v  DSS56

* Q1: Power MOSFET — drain=heater_lo, gate=gate_node, source=GND
M_Q1  heater_lo gate_node 0 0  TM15N10D

* Bulk capacitors on 24V rail (cosmetic — V_24V is ideal source)
C_bulk  v24 0  100u  IC=24
C_cer1  v24 0  10u   IC=24
C_cer2  v24 0  10u   IC=24

* =====================================================================
* Gate Driver Circuit
* =====================================================================

* R_gate_pull (1M): charges Q1 gate toward 24V when Q7 is OFF
R_gate_pull  v24  gate_node  1Meg

* D_zener (10V): clamps gate_node to 10V (anode=GND, cathode=gate)
D_zener  0  gate_node  DZ10V

* Q7 (q_driver): pulls gate_node to GND when ON
*   drain=gate_node, gate=driver_gate, source=GND
M_Q7  gate_node  driver_gate  0  0  N2N7002

* Q7 gate bias: 24V divider (R_bias 4.7M / R_gate_pd 1M → 4.2V)
R_bias     v24          driver_gate  4.7Meg
R_gate_pd  driver_gate  0            1Meg

* Q6 (q_ctrl): MCU interface, pulls driver_gate to GND when ON
*   drain=driver_gate, gate=ctrl_gate, source=GND
M_Q6  driver_gate  ctrl_gate  0  0  N2N7002

* Q6 gate: PA8 through R_ctrl (10k), pulled down by R_ctrl_pd (100k)
R_ctrl     pa8        ctrl_gate  10k
R_ctrl_pd  ctrl_gate  0          100k

* Q4 (q_wd): kill switch — clamps gate_node to GND on latch fault
*   drain=gate_node, gate=pnp_coll, source=GND
M_Q4  gate_node  pnp_coll  0  0  N2N7002

* =====================================================================
* SCR Latch
* =====================================================================

* D_iso (1N4148): cathode=rstn, anode=d_iso_a
*   Isolates latch from RSTn so MCU can still boot after latch fires
D_iso  d_iso_a  rstn  D1N4148

* R_base (10k): limits trigger current into PNP base
R_base  d_iso_a  pnp_base  10k

* R_pnp_base (100k): pulls PNP base to 3.3V (keeps Q2 OFF normally)
R_pnp_base  v3v3  pnp_base  100k

* Q2 (SS8550 PNP): trigger transistor
*   collector=pnp_coll, base=pnp_base, emitter=3.3V
Q_Q2  pnp_coll  pnp_base  v3v3  SS8550

* R_wd_pd (10k): pulls pnp_coll (Q4 gate) LOW when Q2 is OFF
R_wd_pd  pnp_coll  0  10k

* R_fb (100k): feedback from PNP collector into latch loop
R_fb  pnp_coll  fb_out  100k

* Q5 (q_arm): PGOOD-gated arming switch in feedback path
*   drain=fb_out, gate=arm_node, source=latch_base, body=latch_base
M_Q5  fb_out  arm_node  latch_base  latch_base  N2N7002

* Q3 (MMBT3904 NPN): latch transistor — holds PNP base LOW
*   collector=pnp_base, base=latch_base, emitter=GND
Q_Q3  pnp_base  latch_base  0  MMBT3904

* R_latch_pd (1M): bleeds latch_base to GND (prevents false trigger)
R_latch_pd  latch_base  0  1Meg

* =====================================================================
* PGOOD Arming Circuit
* =====================================================================

* R_arm (1M) + C_arm (1uF): tau = 1s delay before latch is armed
R_arm  pgood     arm_node  1Meg
C_arm  arm_node  0         1u  IC=0

* =====================================================================
* SPICE Models
* =====================================================================

* --- Power MOSFET (TM15N10D: 100V/15A, Rds=75mΩ @ Vgs=10V) ---
.MODEL TM15N10D NMOS (LEVEL=1 VTO=2.5 KP=1.78 LAMBDA=0.01
+  CBD=200p CGS=500p RS=0.04 RD=0.04)

* --- Small-signal N-FET (2N7002: Rds~3Ω @ Vgs=4.5V) ---
.MODEL N2N7002 NMOS (LEVEL=1 VTO=1.8 KP=0.12 LAMBDA=0.04
+  CBD=35p CGS=20p RS=0.5 RD=0.5)

* --- PNP BJT (SS8550) ---
.MODEL SS8550 PNP (IS=5e-14 BF=200 NF=1 VAF=100 IKF=0.4
+  ISE=0 NE=1.5 BR=4 NR=1 VAR=0 IKR=0 ISC=0 NC=2
+  RB=10 RE=0.5 RC=0.5 CJE=30p CJC=10p TF=0.5n TR=50n)

* --- NPN BJT (MMBT3904) ---
.MODEL MMBT3904 NPN (IS=6.734e-15 BF=416.4 NF=1.013 VAF=74.03
+  IKF=0.1 ISE=6.734e-15 NE=1.5 BR=0.7389 NR=1.005 VAR=28
+  IKR=0 ISC=0 NC=1.5 RB=10 RE=0.2 RC=1
+  CJE=3.5p CJC=4p TF=0.3n TR=20n)

* --- Signal diode (1N4148) ---
.MODEL D1N4148 D (IS=2.52e-9 RS=0.568 N=1.752 BV=100 IBV=100u
+  CJO=4p VJ=0.7 M=0.45 TT=5n)

* --- Schottky diode (SS56, 60V/5A) ---
.MODEL DSS56 D (IS=1e-5 RS=0.05 N=1.05 BV=60 IBV=100u
+  CJO=100p VJ=0.4 M=0.5)

* --- Zener 10V (MM3Z10) ---
.MODEL DZ10V D (IS=1e-14 BV=10 IBV=5m RS=10 N=1.05 CJO=5p)

* =====================================================================
* Simulation Control
* =====================================================================
.tran 100u 12 UIC

.control
run
wrdata heater_sim.dat v(pa8) v(gate_node) v(heater_lo) v(pnp_coll) v(arm_node) v(rstn) v(pgood) v(driver_gate) v(ctrl_gate) v(pnp_base) v(latch_base)
quit
.endc

.end
